// Copyright 2026 Politecnico di Torino
// Licensed under the Apache License, Version 2.0, see LICENSE for details.
// SPDX-License-Identifier: Apache-2.0
//
// Power manager registers, generated from the Power_manager configuration.
// PD_<name>_* registers exist for every power domain, CG_<name> for every
// clock gate group, *_<h> for every hart.
{ name: "power_manager",
  clock_primary: "clk_i",
  bus_interfaces: [
    { protocol: "reg_iface", direction: "device" }
  ],
  regwidth: "32",
  registers: [
    { name:     "WAKEUP_STATE_0",
      desc:     "Set by SW before switching hart 0 off: the boot ROM then resumes from RESTORE_ADDR instead of booting",
      resval:   "0",
      swaccess: "rw",
      hwaccess: "none",
      fields: [
        { bits: "0", name: "WAKEUP_STATE", desc: "1: hart 0 resumes from RESTORE_ADDR after reset" }
      ]
    }
    { name:     "RESTORE_ADDR_LO_0",
      desc:     "Restore address of hart 0, low 32 bits",
      resval:   "0",
      swaccess: "rw",
      hwaccess: "none",
      fields: [
        { bits: "31:0", name: "RESTORE_ADDR_LO", desc: "Restore address, bits 31:0" }
      ]
    }
    { name:     "RESTORE_ADDR_HI_0",
      desc:     "Restore address of hart 0, high 32 bits",
      resval:   "0",
      swaccess: "rw",
      hwaccess: "none",
      fields: [
        { bits: "31:0", name: "RESTORE_ADDR_HI", desc: "Restore address, bits 63:32" }
      ]
    }
    { name:     "WAKEUP_TIMER",
      desc:     "Wake-up timer reload value, in clock cycles",
      resval:   "0",
      swaccess: "rw",
      hwaccess: "hro",
      fields: [
        { bits: "31:0", name: "WAKEUP_TIMER", desc: "Cycles from WAKEUP_TIMER_EN rising to expiry" }
      ]
    }
    { name:     "WAKEUP_TIMER_EN",
      desc:     "Wake-up timer enable",
      resval:   "0",
      swaccess: "rw",
      hwaccess: "hro",
      fields: [
        { bits: "0", name: "WAKEUP_TIMER_EN", desc: "0->1 loads WAKEUP_TIMER and starts counting, 0 stops and clears EXPIRED" }
      ]
    }
    { name:     "WAKEUP_TIMER_STATUS",
      desc:     "Wake-up timer status",
      swaccess: "ro",
      hwaccess: "hwo",
      hwext:    "true",
      fields: [
        { bits: "0", name: "EXPIRED", desc: "The timer reached zero (wake source)" }
      ]
    }
    { name:     "PD_CPU_MODE",
      desc:     "Sleep mode of power domain cpu (supports: clock_gate, off)",
      resval:   "0",
      swaccess: "rw",
      hwaccess: "hro",
      fields: [
        { bits: "1:0", name: "MODE", desc: "0: clock_gate, 1: retentive, 2: off. An unsupported mode falls back to clock_gate" }
      ]
    }
    { name:     "PD_CPU_SLEEP_EN",
      desc:     "Arms the sleep of power domain cpu",
      resval:   "0",
      swaccess: "rw",
      hwaccess: "hrw",
      fields: [
        { bits: "0", name: "SLEEP_EN", desc: "1: sleep once every core in WFI_MASK is in WFI. 0 wakes the domain. Cleared by HW on wake" }
      ]
    }
    { name:     "PD_CPU_WFI_MASK",
      desc:     "Cores of power domain cpu must wait for",
      resval:   "1",
      swaccess: "rw",
      hwaccess: "hro",
      fields: [
        { bits: "0", name: "WFI_MASK", desc: "Cores that must be in WFI before sleeping (0: sleep at once). Their debug requests wake the domain" }
      ]
    }
    { name:     "PD_CPU_WAKE_MASK_LO",
      desc:     "Interrupt sources 31:0 that wake power domain cpu",
      resval:   "0",
      swaccess: "rw",
      hwaccess: "hro",
      fields: [
        { bits: "31:0", name: "WAKE_MASK_LO", desc: "One bit per PLIC source" }
      ]
    }
    { name:     "PD_CPU_WAKE_MASK_HI",
      desc:     "Interrupt sources 63:32 that wake power domain cpu",
      resval:   "0",
      swaccess: "rw",
      hwaccess: "hro",
      fields: [
        { bits: "31:0", name: "WAKE_MASK_HI", desc: "One bit per PLIC source" }
      ]
    }
    { name:     "PD_CPU_WAKE_TIMER",
      desc:     "Wake power domain cpu when the wake-up timer expires",
      resval:   "0",
      swaccess: "rw",
      hwaccess: "hro",
      fields: [
        { bits: "0", name: "WAKE_TIMER", desc: "1: the wake-up timer wakes the domain" }
      ]
    }
    { name:     "PD_CPU_DELAY",
      desc:     "Cycles between two steps of the sleep/wake sequence of power domain cpu",
      resval:   "4",
      swaccess: "rw",
      hwaccess: "hro",
      fields: [
        { bits: "15:0", name: "DELAY", desc: "Cycles between steps" }
      ]
    }
    { name:     "PD_CPU_WAIT_ACK",
      desc:     "Wait for the power switch ack of power domain cpu when switching on",
      resval:   "1",
      swaccess: "rw",
      hwaccess: "hro",
      fields: [
        { bits: "0", name: "WAIT_ACK", desc: "1: wait for the ack, 0: ignore it" }
      ]
    }
    { name:     "PD_CPU_STATUS",
      desc:     "Status of power domain cpu",
      swaccess: "ro",
      hwaccess: "hwo",
      hwext:    "true",
      fields: [
        { bits: "0", name: "SLEEPING", desc: "The domain is fully asleep" }
        { bits: "1", name: "ACK", desc: "Power switch ack (1: powered)" }
        { bits: "2", name: "AWAKE", desc: "The domain is fully on" }
      ]
    }
    { name:     "PD_LLC_MODE",
      desc:     "Sleep mode of power domain llc (supports: clock_gate, retentive, off)",
      resval:   "0",
      swaccess: "rw",
      hwaccess: "hro",
      fields: [
        { bits: "1:0", name: "MODE", desc: "0: clock_gate, 1: retentive, 2: off. An unsupported mode falls back to clock_gate" }
      ]
    }
    { name:     "PD_LLC_SLEEP_EN",
      desc:     "Arms the sleep of power domain llc",
      resval:   "0",
      swaccess: "rw",
      hwaccess: "hrw",
      fields: [
        { bits: "0", name: "SLEEP_EN", desc: "1: sleep once every core in WFI_MASK is in WFI. 0 wakes the domain. Cleared by HW on wake" }
      ]
    }
    { name:     "PD_LLC_WFI_MASK",
      desc:     "Cores of power domain llc must wait for",
      resval:   "0",
      swaccess: "rw",
      hwaccess: "hro",
      fields: [
        { bits: "0", name: "WFI_MASK", desc: "Cores that must be in WFI before sleeping (0: sleep at once). Their debug requests wake the domain" }
      ]
    }
    { name:     "PD_LLC_WAKE_MASK_LO",
      desc:     "Interrupt sources 31:0 that wake power domain llc",
      resval:   "0",
      swaccess: "rw",
      hwaccess: "hro",
      fields: [
        { bits: "31:0", name: "WAKE_MASK_LO", desc: "One bit per PLIC source" }
      ]
    }
    { name:     "PD_LLC_WAKE_MASK_HI",
      desc:     "Interrupt sources 63:32 that wake power domain llc",
      resval:   "0",
      swaccess: "rw",
      hwaccess: "hro",
      fields: [
        { bits: "31:0", name: "WAKE_MASK_HI", desc: "One bit per PLIC source" }
      ]
    }
    { name:     "PD_LLC_WAKE_TIMER",
      desc:     "Wake power domain llc when the wake-up timer expires",
      resval:   "0",
      swaccess: "rw",
      hwaccess: "hro",
      fields: [
        { bits: "0", name: "WAKE_TIMER", desc: "1: the wake-up timer wakes the domain" }
      ]
    }
    { name:     "PD_LLC_DELAY",
      desc:     "Cycles between two steps of the sleep/wake sequence of power domain llc",
      resval:   "4",
      swaccess: "rw",
      hwaccess: "hro",
      fields: [
        { bits: "15:0", name: "DELAY", desc: "Cycles between steps" }
      ]
    }
    { name:     "PD_LLC_WAIT_ACK",
      desc:     "Wait for the power switch ack of power domain llc when switching on",
      resval:   "1",
      swaccess: "rw",
      hwaccess: "hro",
      fields: [
        { bits: "0", name: "WAIT_ACK", desc: "1: wait for the ack, 0: ignore it" }
      ]
    }
    { name:     "PD_LLC_STATUS",
      desc:     "Status of power domain llc",
      swaccess: "ro",
      hwaccess: "hwo",
      hwext:    "true",
      fields: [
        { bits: "0", name: "SLEEPING", desc: "The domain is fully asleep" }
        { bits: "1", name: "ACK", desc: "Power switch ack (1: powered)" }
        { bits: "2", name: "AWAKE", desc: "The domain is fully on" }
      ]
    }
    { name:     "PD_EXTERNAL_0_MODE",
      desc:     "Sleep mode of power domain external_0 (supports: clock_gate, retentive, off)",
      resval:   "0",
      swaccess: "rw",
      hwaccess: "hro",
      fields: [
        { bits: "1:0", name: "MODE", desc: "0: clock_gate, 1: retentive, 2: off. An unsupported mode falls back to clock_gate" }
      ]
    }
    { name:     "PD_EXTERNAL_0_SLEEP_EN",
      desc:     "Arms the sleep of power domain external_0",
      resval:   "0",
      swaccess: "rw",
      hwaccess: "hrw",
      fields: [
        { bits: "0", name: "SLEEP_EN", desc: "1: sleep once every core in WFI_MASK is in WFI. 0 wakes the domain. Cleared by HW on wake" }
      ]
    }
    { name:     "PD_EXTERNAL_0_WFI_MASK",
      desc:     "Cores of power domain external_0 must wait for",
      resval:   "0",
      swaccess: "rw",
      hwaccess: "hro",
      fields: [
        { bits: "0", name: "WFI_MASK", desc: "Cores that must be in WFI before sleeping (0: sleep at once). Their debug requests wake the domain" }
      ]
    }
    { name:     "PD_EXTERNAL_0_WAKE_MASK_LO",
      desc:     "Interrupt sources 31:0 that wake power domain external_0",
      resval:   "0",
      swaccess: "rw",
      hwaccess: "hro",
      fields: [
        { bits: "31:0", name: "WAKE_MASK_LO", desc: "One bit per PLIC source" }
      ]
    }
    { name:     "PD_EXTERNAL_0_WAKE_MASK_HI",
      desc:     "Interrupt sources 63:32 that wake power domain external_0",
      resval:   "0",
      swaccess: "rw",
      hwaccess: "hro",
      fields: [
        { bits: "31:0", name: "WAKE_MASK_HI", desc: "One bit per PLIC source" }
      ]
    }
    { name:     "PD_EXTERNAL_0_WAKE_TIMER",
      desc:     "Wake power domain external_0 when the wake-up timer expires",
      resval:   "0",
      swaccess: "rw",
      hwaccess: "hro",
      fields: [
        { bits: "0", name: "WAKE_TIMER", desc: "1: the wake-up timer wakes the domain" }
      ]
    }
    { name:     "PD_EXTERNAL_0_DELAY",
      desc:     "Cycles between two steps of the sleep/wake sequence of power domain external_0",
      resval:   "4",
      swaccess: "rw",
      hwaccess: "hro",
      fields: [
        { bits: "15:0", name: "DELAY", desc: "Cycles between steps" }
      ]
    }
    { name:     "PD_EXTERNAL_0_WAIT_ACK",
      desc:     "Wait for the power switch ack of power domain external_0 when switching on",
      resval:   "1",
      swaccess: "rw",
      hwaccess: "hro",
      fields: [
        { bits: "0", name: "WAIT_ACK", desc: "1: wait for the ack, 0: ignore it" }
      ]
    }
    { name:     "PD_EXTERNAL_0_STATUS",
      desc:     "Status of power domain external_0",
      swaccess: "ro",
      hwaccess: "hwo",
      hwext:    "true",
      fields: [
        { bits: "0", name: "SLEEPING", desc: "The domain is fully asleep" }
        { bits: "1", name: "ACK", desc: "Power switch ack (1: powered)" }
        { bits: "2", name: "AWAKE", desc: "The domain is fully on" }
      ]
    }
    { name:     "CG_UART",
      desc:     "Clock gate of uart",
      resval:   "0",
      swaccess: "rw",
      hwaccess: "hro",
      fields: [
        { bits: "0", name: "CG", desc: "1: clock gated" }
      ]
    }
  ]
}
